V1 vin 0 AC 1
R1 vin vout 3.3k
C1 vout 0 100n
.ac dec 100 1 100000
.save V(vin) V(vout)
.end
