* ============================================================================
*  CL-YD-301  Front-end de carga  -  Analisis AC (respuesta en frecuencia)
*  Transferencia  V(out)/F  [V/N]  -> esquina de paso-alto y ancho de banda
* ============================================================================
.include C:\Users\jesus\Documents\LTspiceXVII\lib\sub\OPAx134.lib
.include C:\Users\jesus\Documents\Fundamentos_Analogicas\Simulaciones Ltspice\models\LSK170.lib

.param Sq=4p  Cs=7p  Rins=1e13

* Excitacion: fuerza unitaria en AC (1 N), para obtener V/N
Vforce  force 0  AC 1

Bvoc   voc 0   V = (Sq/Cs)*V(force)
Cs     voc g   {Cs}
Rins   voc g   {Rins}
R2     g 0     588.24Meg

V1     vdd 0  3
J1     vdd g s  LSK170A
R1     s 0    300

V4     vcc 0   12
V5     vee 0  -12
R4     s   np   10k
R6     np  0    10k
R5     nn  0    10k
R3     out nn   10k
Xopa   np nn vcc vee out  OPAx134
R7     out 0    10k

.save V(g) V(s) V(out)
.ac dec 200 0.01 100meg
.end
