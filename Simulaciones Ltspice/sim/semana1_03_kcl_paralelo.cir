* Semana 1.3 - KCL y reparto de corriente en ramas paralelas
V1 bus 0 5
R1 bus 0 1k
R2 bus 0 2.2k
R3 bus 0 3.3k
.op
.meas op I_R1_mA PARAM V(bus)/1k*1e3
.meas op I_R2_mA PARAM V(bus)/2.2k*1e3
.meas op I_R3_mA PARAM V(bus)/3.3k*1e3
.meas op I_source_mA PARAM -I(V1)*1e3
.meas op KCL_error_uA PARAM (-I(V1)-(V(bus)/1k+V(bus)/2.2k+V(bus)/3.3k))*1e6
.meas op Req_parallel_ohm PARAM V(bus)/(-I(V1))
.save V(bus) I(V1) I(R1) I(R2) I(R3)
.end
