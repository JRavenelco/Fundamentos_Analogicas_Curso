* Semana 4.4 - Conmutador BJT de saturacion forzada con carga RC
* Q1 es un inversor/pull-down; RPU suministra la corriente de base de Q2.
* Entrada alta -> Q1 ON -> Q2 OFF -> C carga por RC+RSER.
* Entrada baja -> Q1 OFF -> Q2 ON -> C descarga por RSER y Q2.

.param VCC=5 RB1=2k RPU=910 RCVAL=220 RSER=220 CLOAD=5u
VCC vcc 0 {VCC}
VIN vin 0 PULSE(0 5 1m 10n 10n 10m 20m)
RB1 vin b1 {RB1}
Q1 b2 b1 0 QBC548_EDU
RPU vcc b2 {RPU}
Q2 n1 b2 0 QBC548_EDU
RC vcc n1 {RCVAL}
RSER n1 n2 {RSER}
CLOAD n2 0 {CLOAD}

* Modelo generico para aprendizaje; comprobar el BC548 real con su datasheet.
.model QBC548_EDU NPN(IS=1e-14 BF=300 VAF=100 RB=20 CJE=10p CJC=4p TF=0.5n)
.tran 0 50m 0 1u

.meas tran VC_CHARGED AVG V(n2) FROM 9m TO 10.5m
.meas tran VC_DISCHARGED AVG V(n2) FROM 19m TO 20.5m
.meas tran VCE2_ON AVG V(n1) FROM 18m TO 20m
.meas tran IB2_ON AVG Ib(Q2) FROM 15m TO 19m
.meas tran IC2_STEADY AVG Ic(Q2) FROM 18m TO 20m
.meas tran IC2_PEAK MAX Ic(Q2) FROM 11m TO 11.5m
.end
