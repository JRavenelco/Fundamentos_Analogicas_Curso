* Semana 3.3 - Realimentacion por emisor
VCC vcc 0 12
RB vcc base 470k
RC vcc cole 3.3k
RE emis 0 1k
Q1 cole base emis QNPN
.model QNPN NPN(BF={BETA})
.param BETA=50
.step param BETA list 50 100 150 200 300
.op
.meas op IC_mA PARAM I(RC)*1e3
.meas op VCE_V PARAM V(cole)-V(emis)
.end
