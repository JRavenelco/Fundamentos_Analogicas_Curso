* Semana 4.1 - Etapa 1: PWM 3.3 V, RG de compuerta y NMOS lado bajo con carga resistiva
* Montaje: GP -- RG=100R -- gate; fuente a GND; carga RL=100R de +12 V al drenaje.
* La salida de drenaje queda invertida respecto al PWM (como en la semana 3 con el TBJ).

.param VCC=12 VPWM=3.3 RG=100 RL=100
VCC vcc 0 {VCC}
VPWM gpio 0 PULSE(0 {VPWM} 0 1n 1n 5u 10u)
RG gpio gate {RG}
M1 drain gate 0 0 NMOS1
RL vcc drain {RL}

* MOSFET de nivel logico: Vth baja (2.1 V) y KP alta para saturar con 3.3 V en el gate.
.model NMOS1 NMOS(VTO=2.1 KP=1.0 LAMBDA=0.01)

.tran 0 40u 0 10n

.meas tran VGS_ON AVG V(gate) FROM 11u TO 14u
.meas tran VDS_ON_MIN MIN V(drain) FROM 11u TO 14u
.meas tran VDS_OFF_MAX MAX V(drain) FROM 21u TO 29u
.meas tran ID_ON AVG I(RL) FROM 11u TO 14u
.end
