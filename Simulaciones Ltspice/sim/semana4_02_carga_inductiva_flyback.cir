* Semana 4.2A - Motor DC equivalente CON diodo de libre circulacion
* D1: anodo al drenaje, catodo a VCC. El valor de clamp es VCC+VF(I,T),
* no un 5.7 V universal. La corriente de la bobina mantiene su sentido.

.param VCC=5 VDRV=12 RDRV=10 RG=100 LPLACE=100m RMEQ=12.5 QGMAX=67n
VCC vcc 0 {VCC}
VDRV driver 0 PULSE(0 {VDRV} 0 10n 10n 40m 80m)
RDRV driver gpio {RDRV}
RG gpio gate {RG}
X1 drain gate 0 IRF640N_EDU
* Modelo terminal pedagogico: RMEQ representa el punto nominal cargado
* (5 V/0.4 A=12.5 ohm, envolvente conservadora). LPLACE es provisional:
* sustituir por la medida real. El motor es nominal de 6 V y se alimenta a 5 V.
LMOTOR vcc lnode {LPLACE}
RMOTOR lnode drain {RMEQ}
D1 drain vcc DFLY_EDU
CGEQ gate 0 {QGMAX/VDRV}

* Diodo generico de laboratorio; sustituir por el modelo del componente real.
.model DFLY_EDU D(IS=5n RS=0.20 N=1.75 CJO=25p TT=2u BV=100 IBV=10u)
.include semana4_irf640n_educativo.lib
.tran 0 200m 0 5u

.meas tran VDS_CLAMP_MAX MAX V(drain) FROM 40m TO 60m
.meas tran ID_END_ON AVG I(RMOTOR) FROM 39m TO 39.8m
.meas tran IFLY_PEAK MAX I(D1) FROM 40m TO 40.5m
.meas tran IFLY_3MS AVG I(D1) FROM 42.9m TO 43.1m
.end
