V1 vin 0 PULSE(0 5 0 1u 1u 20m 40m)
R1 vin vout 10k
C1 vout 0 1u
.tran 0 80m 0 50u
.save V(vin) V(vout)
.end
